ADE simulation setup
Test LVTHVT-Low_power_8X8_CAM_ARRAY_1: LVTHVT-Low_power/8X8_CAM_ARRAY/schematic, simulator spectre
  Models: /home/cadence/install_RB_8.7/FOUNDRY/UMC65/Designkits/Cadence_IC6/G-9FD-LOGIC_MIXED_MODE65N-LL_LOW_K_UMK65FDKLLC00000OA-FDK-Ver.B11_PB/umc65ll/../Models/Spectre/l65ll_v181.lib.scs[tt_ll_rvt12, tt_ll_hvt12, tt_ll_lvt12, tt_ll_io18, tt_ll_io25od33, tt_ll_io33, tt_ll_nvt12, tt_ll_nvt12_bpw, tt_ll_nvt18, tt_ll_nvt18_bpw, tt_ll_nvt25od33, tt_ll_nvt25od33_bpw, tt_ll_nvt33, tt_ll_nvt33_bpw, tt_ll_bjt, tt_ll_diode, tt_ll_momcaps, tt_ll_ncap12, tt_ll_ncap18, tt_ll_ncap25, tt_ll_ncap33, tt_ll_pcap12, tt_ll_pcap18, tt_ll_pcap25, tt_ll_pcap33, tt_ll_res], /home/cadence/install_RB_8.7/FOUNDRY/UMC65/Designkits/Cadence_IC6/G-9FD-LOGIC_MIXED_MODE65N-LL_LOW_K_UMK65FDKLLC00000OA-FDK-Ver.B11_PB/umc65ll/../Models/Spectre/L65LL_RVT12_V101_RF.lib.scs[tt], /home/cadence/install_RB_8.7/FOUNDRY/UMC65/Designkits/Cadence_IC6/G-9FD-LOGIC_MIXED_MODE65N-LL_LOW_K_UMK65FDKLLC00000OA-FDK-Ver.B11_PB/umc65ll/../Models/Spectre/L65LL_HVT12_V101_RF.lib.scs[tt], /home/cadence/install_RB_8.7/FOUNDRY/UMC65/Designkits/Cadence_IC6/G-9FD-LOGIC_MIXED_MODE65N-LL_LOW_K_UMK65FDKLLC00000OA-FDK-Ver.B11_PB/umc65ll/../Models/Spectre/L65LL_LVT12_V101_RF.lib.scs[tt], /home/cadence/install_RB_8.7/FOUNDRY/UMC65/Designkits/Cadence_IC6/G-9FD-LOGIC_MIXED_MODE65N-LL_LOW_K_UMK65FDKLLC00000OA-FDK-Ver.B11_PB/umc65ll/../Models/Spectre/L65LL_IO18_V101_RF.lib.scs[tt], /home/cadence/install_RB_8.7/FOUNDRY/UMC65/Designkits/Cadence_IC6/G-9FD-LOGIC_MIXED_MODE65N-LL_LOW_K_UMK65FDKLLC00000OA-FDK-Ver.B11_PB/umc65ll/../Models/Spectre/L65LL_IO25_V101_RF.lib.scs[tt], /home/cadence/install_RB_8.7/FOUNDRY/UMC65/Designkits/Cadence_IC6/G-9FD-LOGIC_MIXED_MODE65N-LL_LOW_K_UMK65FDKLLC00000OA-FDK-Ver.B11_PB/umc65ll/../Models/Spectre/L65LL_IO33_V111_RF.lib.scs[tt], /home/cadence/install_RB_8.7/FOUNDRY/UMC65/Designkits/Cadence_IC6/G-9FD-LOGIC_MIXED_MODE65N-LL_LOW_K_UMK65FDKLLC00000OA-FDK-Ver.B11_PB/umc65ll/../Models/Spectre/L65LL_VARMIS12_V111_RF.lib.scs[typ], /home/cadence/install_RB_8.7/FOUNDRY/UMC65/Designkits/Cadence_IC6/G-9FD-LOGIC_MIXED_MODE65N-LL_LOW_K_UMK65FDKLLC00000OA-FDK-Ver.B11_PB/umc65ll/../Models/Spectre/L65LL_VARMIS18_V111_RF.lib.scs[typ], /home/cadence/install_RB_8.7/FOUNDRY/UMC65/Designkits/Cadence_IC6/G-9FD-LOGIC_MIXED_MODE65N-LL_LOW_K_UMK65FDKLLC00000OA-FDK-Ver.B11_PB/umc65ll/../Models/Spectre/L65LL_VARMIS25_V121_RF.lib.scs[typ], /home/cadence/install_RB_8.7/FOUNDRY/UMC65/Designkits/Cadence_IC6/G-9FD-LOGIC_MIXED_MODE65N-LL_LOW_K_UMK65FDKLLC00000OA-FDK-Ver.B11_PB/umc65ll/../Models/Spectre/L65LL_VARMIS33_V111_RF.lib.scs[typ], /home/cadence/install_RB_8.7/FOUNDRY/UMC65/Designkits/Cadence_IC6/G-9FD-LOGIC_MIXED_MODE65N-LL_LOW_K_UMK65FDKLLC00000OA-FDK-Ver.B11_PB/umc65ll/../Models/Spectre/L65LL_VARDIOP_V101_RF.lib.scs[typ], /home/cadence/install_RB_8.7/FOUNDRY/UMC65/Designkits/Cadence_IC6/G-9FD-LOGIC_MIXED_MODE65N-LL_LOW_K_UMK65FDKLLC00000OA-FDK-Ver.B11_PB/umc65ll/../Models/Spectre/momcaps_array_vp3_rfvcl_V101.lib.scs[typ], /home/cadence/install_RB_8.7/FOUNDRY/UMC65/Designkits/Cadence_IC6/G-9FD-LOGIC_MIXED_MODE65N-LL_LOW_K_UMK65FDKLLC00000OA-FDK-Ver.B11_PB/umc65ll/../Models/Spectre/momcaps_array_vp4_rfvcl_V101.lib.scs[typ], /home/cadence/install_RB_8.7/FOUNDRY/UMC65/Designkits/Cadence_IC6/G-9FD-LOGIC_MIXED_MODE65N-LL_LOW_K_UMK65FDKLLC00000OA-FDK-Ver.B11_PB/umc65ll/../Models/Spectre/momcaps_array_vp5_rfvcl_V101.lib.scs[typ], /home/cadence/install_RB_8.7/FOUNDRY/UMC65/Designkits/Cadence_IC6/G-9FD-LOGIC_MIXED_MODE65N-LL_LOW_K_UMK65FDKLLC00000OA-FDK-Ver.B11_PB/umc65ll/../Models/Spectre/L65_MIMCAPS_20F_KF_V101_RF.lib.scs[tt], /home/cadence/install_RB_8.7/FOUNDRY/UMC65/Designkits/Cadence_IC6/G-9FD-LOGIC_MIXED_MODE65N-LL_LOW_K_UMK65FDKLLC00000OA-FDK-Ver.B11_PB/umc65ll/../Models/Spectre/L65LL_RNPPO_V101_RF.lib.scs[typ], /home/cadence/install_RB_8.7/FOUNDRY/UMC65/Designkits/Cadence_IC6/G-9FD-LOGIC_MIXED_MODE65N-LL_LOW_K_UMK65FDKLLC00000OA-FDK-Ver.B11_PB/umc65ll/../Models/Spectre/L65LL_RNNPO_V101_RF.lib.scs[typ], /home/cadence/install_RB_8.7/FOUNDRY/UMC65/Designkits/Cadence_IC6/G-9FD-LOGIC_MIXED_MODE65N-LL_LOW_K_UMK65FDKLLC00000OA-FDK-Ver.B11_PB/umc65ll/../Models/Spectre/L65LL_RNHR_V101_RF.lib.scs[typ], /home/cadence/install_RB_8.7/FOUNDRY/UMC65/Designkits/Cadence_IC6/G-9FD-LOGIC_MIXED_MODE65N-LL_LOW_K_UMK65FDKLLC00000OA-FDK-Ver.B11_PB/umc65ll/../Models/Spectre/L65_pad_rf_V101.lib.scs[typ]
  Temperature: 27
  Analysis tran: stop=60n errpreset=moderate
Run mode: Single Run, Sweeps and Corners
