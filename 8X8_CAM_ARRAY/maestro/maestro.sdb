ADE simulation setup
Run mode: Single Run, Sweeps and Corners
Tests:
  LVTHVT-Low_power_8X8_CAM_ARRAY_1: LVTHVT-Low_power/8X8_CAM_ARRAY/schematic, simulator spectre
